# Ansys Electronics Desktop project, version 2024.1
materials:
  vacuum: permittivity=1
  copper: permeability=0.999991 conductivity=58000000
  Rogers RO3003 (tm): permittivity=3 dielectric_loss_tangent=0.0013
  Rogers RT/duroid 5880 (tm): permittivity=2.2 dielectric_loss_tangent=0.0009

design HFSSDesign1 (HFSS, HFSS Terminal Network, model units mm)
variables:
  S = 0.06mm
  RATE = 250
  TL = 14mm
  SL = 5mm
  EXT = 0.5mm
  CTHICK = 0.035mm
  SUBT = 1.57mm
  NUDGE = 3.5mm
  MW = 0.1mm
  QWM = 7.43mm
geometry:
  EquationSurface1 = equation_based_surface(XuvFunction=_U YuvFunction=S*_V*EXP(_U*RATE) ZuvFunction=0 uStart=0 uEnd=TL vStart=-1 vEnd=1)
  Rectangle1 = rectangle(corner=(-SL, -S, 0mm), x_size=SL, y_size=2*S)
  EquationSurface1.unite(Rectangle1)
  Rectangle2 [copper] = rectangle(corner=(-SL-EXT, -TL/2, 0mm), x_size=TL+SL+EXT, y_size=TL)
  Rectangle2.subtract(EquationSurface1)
  Rectangle2.thicken(CTHICK)
  Box1 [Rogers RT/duroid 5880 (tm)] = box(corner=(-SL-EXT, -TL/2, -SUBT), size=(TL+SL+EXT, TL, SUBT))
  Rectangle3 = rectangle(corner=(-SL-EXT, NUDGE, -SUBT-CTHICK), x_size=SL+EXT+MW/2, y_size=MW)
  Rectangle4 [copper] = rectangle(corner=(-MW/2, -QWM-S, -SUBT-CTHICK), x_size=MW, y_size=QWM+NUDGE+S)
  Rectangle4.unite(Rectangle3)
  Rectangle4.thicken(CTHICK)
  Rectangle5 = rectangle(corner=(-SL-EXT, NUDGE, CTHICK), y_size=MW, z_size=-SUBT-2*CTHICK)
  RadiatingSurface [vacuum] = region(absolute_offset=10mm on all sides)
  coordinate_system RelativeCS1 = origin=(-41mm, 50mm, 0mm) x=(1mm, 0mm, 0mm) y=(0mm, 1mm, 0mm)
  coordinate_system RelativeCS2 = origin=(-7mm, 0mm, -61mm) x=(1mm, 0mm, 0mm) y=(0mm, 1mm, 0mm) in RelativeCS1
boundaries and excitations:
  Open1: Radiation Objects=RadiatingSurface
  1: Lumped Port Objects=Rectangle5 LumpedPortType=Modal Modes{Mode1{IntLine{(-5.5, 3.55, -1.605) -> (-5.5, 3.55, 0.035)} CharImp=Zpi}} Impedance=50ohm
setups:
  Setup1: HfssDriven Frequency=10GHz MaxDeltaS=0.02 MaximumPasses=6 MinimumPasses=1 MinimumConvergedPasses=1 PercentRefinement=30 BasisOrder=1 PortAccuracy=2 DrivenSolverType="Direct Solver"
    sweep Sweep: 7GHz to 13GHz, 451 points; Type=Interpolating InterpTolerance=0.5 InterpMaxSolns=250 PassivityErrorTolerance=0.0001
source amplitudes:
  1:1: 1V 0deg
radiation setups:
  3D: Infinite Sphere Theta=0deg..180deg step 2deg Phi=-180deg..180deg step 2deg
  Elevation: Infinite Sphere Theta=-180deg..180deg step 1deg Phi=0deg..90deg step 90deg
  Azimuth: Infinite Sphere Theta=90deg..90deg step 0deg Phi=-180deg..180deg step 1deg
  Infinite Sphere1: Infinite Sphere Theta=-180deg..180deg step 2deg Phi=0deg..360deg step 2deg
reports:
  Terminal S Parameter Plot 1: dB(St(1,1)) vs Freq on Setup1 : Sweep; markers m1 at 9.6533333GHz, m2 at 10.253333GHz, m3 at 9.9733333GHz
  Terminal VSWR Plot 1: VSWRt(1) vs Freq on Setup1 : Sweep; markers m1 at 9.76GHz, m2 at 10.253333GHz, m3 at 10GHz
  Gain Plot 1: dB(GainPhi), dB(GainTheta) vs Theta on Setup1 : LastAdaptive, 3D [Phi=0deg Freq=10GHz]
  Gain Plot 2: dB(GainPhi), dB(GainTheta) vs Theta on Setup1 : LastAdaptive, 3D [Phi=0deg,90deg Freq=10GHz]
  Gain Plot 3: dB(GainPhi), dB(GainTheta) vs Theta on Setup1 : LastAdaptive, 3D [Phi=all Freq=10GHz]
  Gain Plot 4: dB(GainPhi), dB(GainTheta) vs Theta on Setup1 : LastAdaptive, 3D [Phi=0deg,90deg Freq=10GHz]
  Gain Plot 5: dB(GainPhi), dB(GainTheta) vs Theta on Setup1 : LastAdaptive, Elevation [Phi=0deg,90deg Freq=10GHz]
  Gain Plot 6: dB(GainPhi), dB(GainTheta) vs Theta on Setup1 : LastAdaptive, Infinite Sphere1 [Phi=0deg,90deg Freq=10GHz]
  Gain Plot 7: dB(GainPhi), dB(GainTheta) vs Theta on Setup1 : LastAdaptive, Azimuth [Phi=0deg,90deg Freq=10GHz]
  Gain Plot 8: dB(GainPhi), dB(GainTheta) vs Theta on Setup1 : LastAdaptive, 3D [Phi=0deg,90deg Freq=10GHz]
  Gain Plot 9: dB(GainPhi), dB(GainTheta) vs Theta on Setup1 : LastAdaptive, Elevation [Phi=0deg,90deg Freq=10GHz]
  Gain Plot 10: dB(GainPhi), dB(GainTheta) vs Theta on Setup1 : LastAdaptive, Infinite Sphere1 [Phi=0deg,90deg Freq=10GHz]
